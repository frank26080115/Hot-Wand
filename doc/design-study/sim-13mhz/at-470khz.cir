* 13 MHz board output passive values at 467.6 kHz; element names inherited from Lite parser
* STP19NF20 estimate from 13 MHz study; passive losses are assumptions, not measured
* Drain clamp, avalanche, core saturation and thermal feedback are NOT modeled
Vcc supply 0 {supply} Rser=50m
Cbulk supply 0 940u Rser=50m
* 12 V drive; 50% at source midpoints (pulse plateau excludes rise time)
* Each split driver path has one 3.6 ohm resistor; 5 ohm includes assumed driver impedance
Vdrive gate 0 PULSE(0 12 0 50n 50n {0.5/f-50n} {1/f}) Rser=5
L1 supply drain 9u Rser=0.1 Rpar=100Meg
M1 drain gate 0 0 STP19NF20_EST
C1 drain 0 1f Rser=30m Rpar=1Meg
C2to5 drain m1 400n Rser=10m Rpar=1Meg
L2 m1 m2 180n Rser=30m Rpar=100Meg
C6to8 m2 0 600p Rser=10m Rpar=100Meg
L3 m2 m3 400n Rser=30m Rpar=100Meg
C9 m3 0 382p Rser=10m Rpar=100Meg
L4 m3 m4 540n Rser=30m Rpar=100Meg
Routput m4 out 1m
* cp=0 represented by a negligible 1 fF shunt
Cextra out 0 235p Rser=10m
Rcable out tip 0.5
Ltip tip rtip {L_tip} Rser=30m Rpar=100Meg
Rtip rtip 0 {R_tip}
.param R_tip=table(TipVal,1,11.6,2,14,3,1.54)
.param L_tip=table(TipVal,1,5.5u,2,7.2u,3,1.7u)
.model STP19NF20_EST VDMOS(Vto=3 Kp=7 Rd=85m Rs=5m Rg=2 Rb=0.1 Cgs=774p Cgdmin=10p Cgdmax=550p A=0.43 Cjo=789p Vj=0.8 M=0.5 Is=10p N=1.3 Tt=65n)
.param f=table(Case,0,467586.206897)
.param cd=table(Case,0,0)
.param cs=table(Case,0,0)
.param cm=table(Case,0,0)
.param ci=table(Case,0,0)
.param co=table(Case,0,0)
.param cp=table(Case,0,0)
.param cl=table(Case,0,0)
.param supply=table(Case,0,20)
.param Case=0
.step param TipVal list 1 2 3
.tran 0 {400/f} 0 1e-08
.options plotwinsize=0 numdgt=7
.save V(gate) V(drain) V(rtip) I(Rtip) V(supply) I(Vcc) Id(M1) I(Routput) V(m4) V(out)
.meas TRAN ptip AVG (V(rtip)*I(Rtip)) FROM {360/f} TO {400/f}
.meas TRAN pin AVG (-V(supply)*I(Vcc)) FROM {360/f} TO {400/f}
.meas TRAN pq AVG (V(drain)*Id(M1)) FROM {360/f} TO {400/f}
.meas TRAN vpeak MAX V(drain)
.end
